* eSim Testbench for 74151 8-to-1 Data Multiplexer

.include 74151.sub
x1 net-_u1-pad1_ net-_u1-pad2_ net-_u1-pad3_ net-_u1-pad4_ net-_u1-pad5_ net-_u1-pad6_ net-_u1-pad7_ net-_u1-pad8_ net-_u1-pad9_ net-_u1-pad10_ net-_u1-pad11_ net-_u1-pad12_ net-_u1-pad13_ net-_u1-pad14_ 74151
* u1  a b c g_n d0 d1 d2 d3 d4 d5 d6 d7 net-_u1-pad1_ net-_u1-pad2_ net-_u1-pad3_ net-_u1-pad4_ net-_u1-pad5_ net-_u1-pad6_ net-_u1-pad7_ net-_u1-pad8_ net-_u1-pad9_ net-_u1-pad10_ net-_u1-pad11_ net-_u1-pad12_ adc_bridge_12
* u2  net-_u1-pad13_ net-_u1-pad14_ y w dac_bridge_2
v1 a gnd dc 0
v2 b gnd dc 0
v3 c gnd dc 0
v4 g_n gnd dc 0
v5 d0 gnd dc 5
v6 d1 gnd dc 0
v7 d2 gnd dc 0
v8 d3 gnd dc 0
v9 d4 gnd dc 0
v10 d5 gnd dc 0
v11 d6 gnd dc 0
v12 d7 gnd dc 0
a1 [a b c g_n d0 d1 d2 d3 d4 d5 d6 d7 ] [net-_u1-pad1_ net-_u1-pad2_ net-_u1-pad3_ net-_u1-pad4_ net-_u1-pad5_ net-_u1-pad6_ net-_u1-pad7_ net-_u1-pad8_ net-_u1-pad9_ net-_u1-pad10_ net-_u1-pad11_ net-_u1-pad12_ ] u1
a2 [net-_u1-pad13_ net-_u1-pad14_ ] [y w ] u2
* Schematic Name: adc_bridge_12, NgSpice Name: adc_bridge
.model u1 adc_bridge(fall_delay=1.0e-9 in_high=2.0 rise_delay=1.0e-9 in_low=1.0 )
* Schematic Name: dac_bridge_2, NgSpice Name: dac_bridge
.model u2 dac_bridge(out_undef=0.5 out_low=0.0 out_high=5.0 t_rise=1.0e-9 t_fall=1.0e-9 input_load=1.0e-12 )
.tran 10e-03 100e-03 0e-03

.control
run
.endc
.end
